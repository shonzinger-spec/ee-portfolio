* 02 - Synchronous buck power stage, 12 V -> 5 V / 3 A, 200 kHz (ngspice 47 port, open loop)
* Same circuit and VDMOS card as sim/buck_sync.cir (LTspice). Dialect changes: the
* LTspice .step/table() becomes a control-block loop with alterparam + reset, .meas
* moves into the control block on let-vectors, and plotwinsize is dropped.
* Run: ngspice -b sim/ngspice/buck_sync_ngspice.cir

.param VIN=12 FSW=200k T={1/FSW} D=0.4195 TD=50n TE=10n
.param VDH=11.3 VDL=12 RDRV=3.1
.param VNOM=5 RLOAD=1.6667 SNUB=1

* Input: lab supply, 2 x 10 uF X7R + 100 uF electrolytic, 1 nH commutation-loop inductance
V1 vsrc 0 {VIN}
Rsrc vsrc vin 10m
C1 vin c1x 20u ic=12
Rc1 c1x 0 3m
C3 vin c3x 100u ic=12
Rc3 c3x 0 150m
Lloop vin dhs 1n

* Half bridge (generic 40 V N-MOSFET, about 7 mohm at Vgs = 11 V)
M1 dhs gh sw NMOS30
M2 sw gl 0 NMOS30
Vgh ghd sw PULSE(0 {VDH} {TD} {TE} {TE} {D*T-TE} {T})
Rgh ghd gh {RDRV}
Vgl gld 0 PULSE(0 {VDL} {2*TD+D*T+TE} {TE} {TE} {T-D*T-2*TD-3*TE} {T})
Rgl gld gl {RDRV}

* RC snubber across the low-side switch: 1.8 ohm + 1 nF (case 3: 1 fF = open)
Rsn sw snb 1.8
Csn snb 0 {SNUB*1n+1f}

* Output filter: 15 uH (DCR 20 mohm), 470 uF polymer (ESR 10 mohm) || 10 uF X7R
L1 sw lx 15u ic={VNOM/RLOAD-0.5}
RL1 lx out 20m
C7 out c7x 470u ic={VNOM}
Rc7 c7x 0 10m
C8 out c8x 10u ic={VNOM}
Rc8 c8x 0 3m
* 5 mohm current shunt, then the load (regulation point is vload)
Rsh out vload 5m
Rload vload 0 {RLOAD}

.model NMOS30 VDMOS(Vto=1.8 Kp=60 Rd=3m Rs=2m Rg=1.2 Rb=4m Cgdmax=0.8n Cgdmin=40p A=0.4 Cgs=1.5n Cjo=0.7n Is=5p N=1.05 Tt=5n)

.tran 20n 1.06m 0 20n uic

.control
set noaskquit
let rl_case = vector(3)
let rl_case[0] = 1.6667
let rl_case[1] = 5
let rl_case[2] = 1.6667
let sn_case = vector(3)
let sn_case[0] = 1
let sn_case[1] = 1
let sn_case[2] = 0
let vn_case = vector(3)
let vn_case[0] = 4.972
let vn_case[1] = 5.056
let vn_case[2] = 4.971
let k = 0
while k < 3
  let rl = rl_case[k]
  let sn = sn_case[k]
  let vn = vn_case[k]
  alterparam RLOAD = $&rl
  alterparam SNUB = $&sn
  alterparam VNOM = $&vn
  reset
  run
  let pin_v = -v(vsrc)*i(v1)
  let pout_v = v(vload)*v(vload)/$&rl
  let pgate_v = -((v(ghd)-v(sw))*i(vgh)+v(gld)*i(vgl))
  let psnub_v = (v(sw)-v(snb))*(v(sw)-v(snb))/1.8
  let case_no = k + 1
  echo "step $&case_no RLOAD=$&rl SNUB=$&sn"
  meas tran vout_avg avg v(vload) from=1.0m to=1.05m
  meas tran vout_pp pp v(vload) from=1.0m to=1.05m
  meas tran il_avg avg l1#branch from=1.0m to=1.05m
  meas tran il_pp pp l1#branch from=1.0m to=1.05m
  meas tran pin avg pin_v from=1.0m to=1.05m
  meas tran pout avg pout_v from=1.0m to=1.05m
  meas tran pgate avg pgate_v from=1.0m to=1.05m
  meas tran psnub avg psnub_v from=1.0m to=1.05m
  meas tran vsw_max max v(sw) from=1.0m to=1.05m
  let eff = pout/pin
  echo "eff = $&eff"
  let k = k + 1
end
quit
.endc
.end
